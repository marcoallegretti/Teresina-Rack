Native-netlist CV input/output transfer: ideal unsaturated high-gain opamps
R124 n27 n178 100000
R125 n28 n179 100000
R126 n29 n180 100000
R127 n30 n181 100000
R128 n31 n182 100000
R129 n32 n183 100000
R130 n33 n184 100000
R131 n34 n185 100000
R132 n198 n178 200000
R133 n198 n179 200000
R134 n198 n180 200000
R135 n198 n181 200000
R136 n198 n182 200000
R137 n198 n183 200000
R138 n198 n184 200000
R139 n198 n185 200000
R140 n43 n178 33000
R141 n44 n179 33000
R142 n45 n180 33000
R143 n46 n181 33000
R144 n47 n182 33000
R145 n48 n183 33000
R146 n49 n184 33000
R147 n50 n185 33000
C126 n43 n178 2.2e-10
C127 n44 n179 2.2e-10
C128 n45 n180 2.2e-10
C129 n46 n181 2.2e-10
C130 n47 n182 2.2e-10
C131 n48 n183 2.2e-10
C132 n49 n184 2.2e-10
C133 n50 n185 2.2e-10
R152 n51 n41 1000
R153 n52 n42 1000
R154 n39 0 120000
R155 n40 0 120000
R156 n39 n36 62000
R157 n40 n38 62000
R158 n36 n35 100
R159 n38 n37 100
C138 n41 0 1e-09
C139 n42 0 1e-09
Vref n198 0 -10
Vin input 0 0
Vdac dac 0 0
Einput1 n27 0 input 0 1
Einput2 n28 0 input 0 1
Einput3 n29 0 input 0 1
Einput4 n30 0 input 0 1
Einput5 n31 0 input 0 1
Einput6 n32 0 input 0 1
Einput7 n33 0 input 0 1
Einput8 n34 0 input 0 1
Edac1 n51 0 dac 0 1
Rload1 n35 0 100k
Edac2 n52 0 dac 0 1
Rload2 n37 0 100k
EU13_1 n43 0 0 n178 1e8
EU13_7 n44 0 0 n179 1e8
EU13_8 n45 0 0 n180 1e8
EU13_14 n46 0 0 n181 1e8
EU14_1 n47 0 0 n182 1e8
EU14_7 n48 0 0 n183 1e8
EU14_8 n49 0 0 n184 1e8
EU14_14 n50 0 0 n185 1e8
EU15_1 n36 0 n41 n39 1e8
EU15_7 n38 0 n42 n40 1e8
.control
dc Vin -5 5 5
meas dc cv1_neg5 FIND v(n43) AT=-5
meas dc cv1_zero FIND v(n43) AT=0
meas dc cv1_pos5 FIND v(n43) AT=5
meas dc cv2_neg5 FIND v(n44) AT=-5
meas dc cv2_zero FIND v(n44) AT=0
meas dc cv2_pos5 FIND v(n44) AT=5
meas dc cv3_neg5 FIND v(n45) AT=-5
meas dc cv3_zero FIND v(n45) AT=0
meas dc cv3_pos5 FIND v(n45) AT=5
meas dc cv4_neg5 FIND v(n46) AT=-5
meas dc cv4_zero FIND v(n46) AT=0
meas dc cv4_pos5 FIND v(n46) AT=5
meas dc cv5_neg5 FIND v(n47) AT=-5
meas dc cv5_zero FIND v(n47) AT=0
meas dc cv5_pos5 FIND v(n47) AT=5
meas dc cv6_neg5 FIND v(n48) AT=-5
meas dc cv6_zero FIND v(n48) AT=0
meas dc cv6_pos5 FIND v(n48) AT=5
meas dc cv7_neg5 FIND v(n49) AT=-5
meas dc cv7_zero FIND v(n49) AT=0
meas dc cv7_pos5 FIND v(n49) AT=5
meas dc cv8_neg5 FIND v(n50) AT=-5
meas dc cv8_zero FIND v(n50) AT=0
meas dc cv8_pos5 FIND v(n50) AT=5
dc Vdac 0 3.3 3.3
meas dc dac1_full FIND v(n35) AT=3.3
meas dc dac2_full FIND v(n37) AT=3.3
quit
.endc
.end
